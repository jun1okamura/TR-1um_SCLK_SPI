** tr_1um_3wire_SPI.spice -- chip-level LVS reference netlist.
** GENERATED by scripts/gen_lvs_spice_top.py; do not edit by hand.
**   core  : layout/spi_slave_sclk_nrow_fm.spice
**   frame : lef/OSS_FRAME_GIO.spice
**   map   : layout/chip/gio_connections.json
**
** x1 = OSS_FRAME_GIO, x2 = spi_slave_sclk_nrow_fm.  A net named NC_*
** is genuinely unconnected on both sides and gets its own unique name,
** so LVS sees each one floating on its own as the silicon has it.
** The top subckt declares all 16 bond-pad ports (P1-P7, VSS, P9-P15,
** VDD -- P8 does not exist in this frame), matching the pin markers
** scripts/add_top_pins.py placed in the layout.  The counts have to
** agree or KLayout will not attempt the match at all.

** sch_path: /Users/okamura/Dropbox/91_OpenPDK/TR-1um/libs.tech/xschem/TR-1um_frame/OSS_FRAME_GIO.sch
.subckt OSS_FRAME_GIO P1 VDD P2 P15 P14 P3 P4 P13 P5 P12 P6 P11 P10 P7 P9 VSS HIZ1 HIZ2 HIZ9 HIZ10 HIZ3 HIZ4 HIZ11 HIZ5 HIZ12 HIZ6
+ HIZ13 HIZ14 HIZ7 HIZ15 OUT1 OUT2 OUT9 OUT10 OUT3 OUT4 OUT11 OUT5 OUT12 OUT6 OUT13 OUT14 OUT7 OUT15
*.PININFO P1:B P2:B P3:B P4:B P5:B P6:B P7:B VSS:B VDD:B P15:B P14:B P13:B P12:B P11:B P10:B P9:B HIZ1:I OUT1:I HIZ2:I OUT2:I
*+ HIZ3:I OUT3:I HIZ4:I OUT4:I HIZ5:I OUT5:I HIZ6:I OUT6:I HIZ7:I OUT7:I HIZ15:I OUT15:I HIZ14:I OUT14:I HIZ13:I OUT13:I HIZ12:I OUT12:I
*+ HIZ11:I OUT11:I HIZ10:I OUT10:I HIZ9:I OUT9:I
x1 VDD P1 VSS HIZ1 OUT1 OSS_ESD_5V_DIO
x2 VDD VSS OSS_ESD_5V_VDD
x3 VDD VSS OSS_ESD_5V_VSS
x4 VDD P2 VSS HIZ2 OUT2 OSS_ESD_5V_DIO
x5 VDD P3 VSS HIZ3 OUT3 OSS_ESD_5V_DIO
x6 VDD P4 VSS HIZ4 OUT4 OSS_ESD_5V_DIO
x7 VDD P5 VSS HIZ5 OUT5 OSS_ESD_5V_DIO
x8 VDD P6 VSS HIZ6 OUT6 OSS_ESD_5V_DIO
x9 VDD P7 VSS HIZ7 OUT7 OSS_ESD_5V_DIO
x10 VDD P15 VSS HIZ15 OUT15 OSS_ESD_5V_DIO
x11 VDD P14 VSS HIZ14 OUT14 OSS_ESD_5V_DIO
x12 VDD P13 VSS HIZ13 OUT13 OSS_ESD_5V_DIO
x13 VDD P12 VSS HIZ12 OUT12 OSS_ESD_5V_DIO
x14 VDD P11 VSS HIZ11 OUT11 OSS_ESD_5V_DIO
x15 VDD P10 VSS HIZ10 OUT10 OSS_ESD_5V_DIO
x16 VDD P9 VSS HIZ9 OUT9 OSS_ESD_5V_DIO
.ends

* expanding   symbol:  OSS_ESD_5V_DIO.sym # of pins=6
** sym_path: /Users/okamura/Dropbox/91_OpenPDK/TR-1um/libs.tech/xschem/TR-1um_frame/OSS_ESD_5V_DIO.sym
** sch_path: /Users/okamura/Dropbox/91_OpenPDK/TR-1um/libs.tech/xschem/TR-1um_frame/OSS_ESD_5V_DIO.sch
.subckt OSS_ESD_5V_DIO VDD PAD VSS HIZ OUT
*.PININFO PAD:B VDD:B VSS:B HIZ:I OUT:I
XXM1 PAD PG VDD VDD PMOS w=300u l=2u
XXM2 PAD NG VSS VSS MNE w=150u l=2u
XXM3 PG PGG VDD VDD PMOS w=20.8u l=1u
XXM4 PG PGG VSS VSS NMOS w=6.8u l=1u
XXM5 PAD VDD VDD VDD PMOS w=200u l=2u
XXM6 PAD VSS VSS VSS MNE w=350u l=2u
XXM7 NG NGG VDD VDD PMOS w=20.8u l=1u
XXM8 NG NGG VSS VSS NMOS w=6.8u l=1u
XXM9 PGG HIZ net2 VDD PMOS w=10.4u l=1u
XXM10 net2 net1 VDD VDD PMOS w=10.4u l=1u
XXM11 PGG net1 VSS VSS NMOS w=3.4u l=1u
XXM12 PGG HIZ VSS VSS NMOS w=3.4u l=1u
XXM13 NGG net1 VDD VDD PMOS w=5.2u l=1u
XXM14 NGG ENB VDD VDD PMOS w=5.2u l=1u
XXM15 NGG ENB net3 VSS NMOS w=3.4u l=1u
XXM16 net3 net1 VSS VSS NMOS w=3.4u l=1u
XXM17 ENB HIZ VDD VDD PMOS w=5.2u l=1u
XXM18 ENB HIZ VSS VSS NMOS w=3.4u l=1u
DD1 VSS HIZ DN AREA=12.96p PJ=14.4u
XXM19 net1 OUT VDD VDD PMOS w=5.2u l=1u
XXM20 net1 OUT VSS VSS NMOS w=3.4u l=1u
DD2 VSS OUT DN AREA=12.96p PJ=14.4u
.ends

* expanding   symbol:  OSS_ESD_5V_VDD.sym # of pins=3
** sym_path: /Users/okamura/Dropbox/91_OpenPDK/TR-1um/libs.tech/xschem/TR-1um_frame/OSS_ESD_5V_VDD.sym
** sch_path: /Users/okamura/Dropbox/91_OpenPDK/TR-1um/libs.tech/xschem/TR-1um_frame/OSS_ESD_5V_VDD.sch
.subckt OSS_ESD_5V_VDD VDD VSS
*.PININFO VSS:B VDD:B VDD:B
XXM5 VSS VDD VDD VDD PMOS w=500u l=2u
XXM6 VDD VSS VSS VSS MNE w=500u l=2u
.ends

* expanding   symbol:  OSS_ESD_5V_VSS.sym # of pins=3
** sym_path: /Users/okamura/Dropbox/91_OpenPDK/TR-1um/libs.tech/xschem/TR-1um_frame/OSS_ESD_5V_VSS.sym
** sch_path: /Users/okamura/Dropbox/91_OpenPDK/TR-1um/libs.tech/xschem/TR-1um_frame/OSS_ESD_5V_VSS.sch
.subckt OSS_ESD_5V_VSS VDD VSS
*.PININFO VSS:B VDD:B VSS:B
XXM3 VSS VDD VDD VDD PMOS w=500u l=2u
XXM4 VDD VSS VSS VSS MNE w=500u l=2u
.ends

** spi_slave_sclk_nrow_fm.spice -- LVS reference netlist for the placed and
** routed core cell spi_slave_sclk_nrow_fm.
** GENERATED by scripts/gen_lvs_spice.py; do not edit by hand.
**   netlist   : layout/spi_slave_sclk_net_pnr.v
**   cell bodies: lef/TR-1um_STDCELL.spice
**   fill counts: layout/placement_nrow_fm.json
.subckt spi_slave_sclk_nrow_fm rstn sclk cs_n dis sdio_in sdio_out sdio_oe_n tx_data_0 tx_data_1 tx_data_2
+ tx_data_3 tx_data_4 tx_data_5 tx_data_6 tx_data_7 rx_data_0 rx_data_1 rx_data_2 rx_data_3
+ rx_data_4 rx_data_5 rx_data_6 rx_data_7 data_oe byte_end VDD GND
*.PININFO rstn:I sclk:I cs_n:I dis:I sdio_in:I sdio_out:O sdio_oe_n:O tx_data_0:I tx_data_1:I tx_data_2:I
*+ tx_data_3:I tx_data_4:I tx_data_5:I tx_data_6:I tx_data_7:I rx_data_0:O rx_data_1:O rx_data_2:O
*+ rx_data_3:O rx_data_4:O rx_data_5:O rx_data_6:O rx_data_7:O data_oe:O byte_end:O VDD:B GND:B
x_35_ VDD cs_n_buf _12_ GND INV_X1
x_36_ VDD dis data_oe GND INV_X1
x_37_ _33__0 _03_ _02_ cs_n_buf VDD byte_end GND NOR4
x_38_ VDD _13_ data_oe byte_end GND AND2_X1
x_47_ bit_cnt_1 VDD _00_ bit_cnt_2 bit_cnt_0 GND OR3
x_48_ tx_data_7 sr_7 msb_done VDD sdio_out GND MUX2
x_49_ VDD _01__0 sdio_in_buf data_oe GND AND2_X1
x_50_ bit_cnt_2 _33__0 bit_cnt_1 data_oe VDD _14_ GND NOR4
x_58_ VDD sdio_oe_n _12_ dis GND NAND2
x_59_ VDD cnt_rstn _12_ rstn GND AND2_X1
x_60_ VDD shift_clk dis sclk_buf_row1 GND XOR2
x_61_ VDD _15_ bit_cnt_0 bit_cnt_1 GND NAND2
x_62_ VDD _34__1 bit_cnt_0 bit_cnt_1 GND XOR2
x_63_ VDD _34__2 bit_cnt_2 _15_ GND XNOR2
x_64_ VDD rx_data_0 rx_data_0 sdio_in_buf sclk_buf_row0 _13_ _22_ GND rstn MUXDFFRB
x_65_ VDD rx_data_1 rx_data_1 sr_0 sclk_buf_row0 _13_ _21_ GND rstn MUXDFFRB
x_66_ VDD rx_data_2 rx_data_2 sr_1 sclk_buf_row0 _13_ _20_ GND rstn MUXDFFRB
x_67_ VDD rx_data_3 rx_data_3 sr_2 sclk_buf_row0 _13_ _19_ GND rstn MUXDFFRB
x_68_ VDD rx_data_4 rx_data_4 sr_3 sclk_buf_row0 _13_ _18_ GND rstn MUXDFFRB
x_69_ VDD rx_data_5 rx_data_5 sr_4 sclk_buf_row1 _13_ _17_ GND rstn MUXDFFRB
x_70_ VDD rx_data_6 rx_data_6 sr_5 sclk_buf_row1 _13_ _16_ GND rstn MUXDFFRB
x_71_ VDD rx_data_7 rx_data_7 sr_6 sclk_buf_row1 _13_ _23_ GND rstn MUXDFFRB
x_72_ VDD _24_ _00_ msb_done cnt_rstn GND shift_clk_row1 DFFRB
x_73_ VDD _25_ _01__0 sr_0 rstn GND shift_clk_row0 DFFRB
x_74_ VDD sr_0 sr_1 tx_data_0 shift_clk_row0 _14_ _26_ GND rstn MUXDFFRB
x_75_ VDD sr_1 sr_2 tx_data_1 shift_clk_row0 _14_ _27_ GND rstn MUXDFFRB
x_76_ VDD sr_2 sr_3 tx_data_2 shift_clk_row0 _14_ _28_ GND rstn MUXDFFRB
x_77_ VDD sr_3 sr_4 tx_data_3 shift_clk_row1 _14_ _29_ GND rstn MUXDFFRB
x_78_ VDD sr_4 sr_5 tx_data_4 shift_clk_row1 _14_ _30_ GND rstn MUXDFFRB
x_79_ VDD sr_5 sr_6 tx_data_5 shift_clk_row1 _14_ _31_ GND rstn MUXDFFRB
x_80_ VDD sr_6 sr_7 tx_data_6 shift_clk_row1 _14_ _32_ GND rstn MUXDFFRB
x_81_ VDD _33__0 _33__0 bit_cnt_0 cnt_rstn GND sclk_buf_row1 DFFRB
x_82_ VDD _03_ _34__1 bit_cnt_1 cnt_rstn GND sclk_buf_row1 DFFRB
x_83_ VDD _02_ _34__2 bit_cnt_2 cnt_rstn GND sclk_buf_row1 DFFRB
xu_bufth_sclk VDD sclk sclk_buf GND BUFTH
xu_bufth_cs_n VDD cs_n cs_n_buf GND BUFTH
xu_bufth_sdio_in VDD sdio_in sdio_in_buf GND BUFTH
xu_buf_sclk_buf_row0 VDD sclk_buf sclk_buf_row0 GND BUF_X2
xu_buf_sclk_buf_row1 VDD sclk_buf sclk_buf_row1 GND BUF_X2
xu_buf_shift_clk_row0 VDD shift_clk shift_clk_row0 GND BUF_X2
xu_buf_shift_clk_row1 VDD shift_clk shift_clk_row1 GND BUF_X2
** fill-cell decoupling capacitors -- one PMOS+NMOS pair per placed
** instance, L/W confirmed against lef/TR-1um_STDCELL.gds by
** scripts/check_cell_spice.py.  FILL2 is a subcircuit CALL and FILL3 is
** inline devices, matching how each extracts from the layout.
xFILL2_1 VDD GND FILL2
xFILL2_2 VDD GND FILL2
xFILL2_3 VDD GND FILL2
xFILL2_4 VDD GND FILL2
xFILL2_5 VDD GND FILL2
xFILL2_6 VDD GND FILL2
xFILL2_7 VDD GND FILL2
xFILL2_8 VDD GND FILL2
xFILL2_9 VDD GND FILL2
xFILL2_10 VDD GND FILL2
xFILL2_11 VDD GND FILL2
X_FILL3_1_p VDD GND VDD VDD PMOS w=21.2u l=8.6u
X_FILL3_1_n GND VDD GND GND NMOS w=13.1u l=8.6u
X_FILL3_2_p VDD GND VDD VDD PMOS w=21.2u l=8.6u
X_FILL3_2_n GND VDD GND GND NMOS w=13.1u l=8.6u
X_FILL3_3_p VDD GND VDD VDD PMOS w=21.2u l=8.6u
X_FILL3_3_n GND VDD GND GND NMOS w=13.1u l=8.6u
X_FILL3_4_p VDD GND VDD VDD PMOS w=21.2u l=8.6u
X_FILL3_4_n GND VDD GND GND NMOS w=13.1u l=8.6u
X_FILL3_5_p VDD GND VDD VDD PMOS w=21.2u l=8.6u
X_FILL3_5_n GND VDD GND GND NMOS w=13.1u l=8.6u
X_FILL3_6_p VDD GND VDD VDD PMOS w=21.2u l=8.6u
X_FILL3_6_n GND VDD GND GND NMOS w=13.1u l=8.6u
X_FILL3_7_p VDD GND VDD VDD PMOS w=21.2u l=8.6u
X_FILL3_7_n GND VDD GND GND NMOS w=13.1u l=8.6u
X_FILL3_8_p VDD GND VDD VDD PMOS w=21.2u l=8.6u
X_FILL3_8_n GND VDD GND GND NMOS w=13.1u l=8.6u
X_FILL3_9_p VDD GND VDD VDD PMOS w=21.2u l=8.6u
X_FILL3_9_n GND VDD GND GND NMOS w=13.1u l=8.6u
X_FILL3_10_p VDD GND VDD VDD PMOS w=21.2u l=8.6u
X_FILL3_10_n GND VDD GND GND NMOS w=13.1u l=8.6u
X_FILL3_11_p VDD GND VDD VDD PMOS w=21.2u l=8.6u
X_FILL3_11_n GND VDD GND GND NMOS w=13.1u l=8.6u
X_FILL3_12_p VDD GND VDD VDD PMOS w=21.2u l=8.6u
X_FILL3_12_n GND VDD GND GND NMOS w=13.1u l=8.6u
X_FILL3_13_p VDD GND VDD VDD PMOS w=21.2u l=8.6u
X_FILL3_13_n GND VDD GND GND NMOS w=13.1u l=8.6u
X_FILL3_14_p VDD GND VDD VDD PMOS w=21.2u l=8.6u
X_FILL3_14_n GND VDD GND GND NMOS w=13.1u l=8.6u
X_FILL3_15_p VDD GND VDD VDD PMOS w=21.2u l=8.6u
X_FILL3_15_n GND VDD GND GND NMOS w=13.1u l=8.6u
X_FILL3_16_p VDD GND VDD VDD PMOS w=21.2u l=8.6u
X_FILL3_16_n GND VDD GND GND NMOS w=13.1u l=8.6u
X_FILL3_17_p VDD GND VDD VDD PMOS w=21.2u l=8.6u
X_FILL3_17_n GND VDD GND GND NMOS w=13.1u l=8.6u
X_FILL3_18_p VDD GND VDD VDD PMOS w=21.2u l=8.6u
X_FILL3_18_n GND VDD GND GND NMOS w=13.1u l=8.6u
X_FILL3_19_p VDD GND VDD VDD PMOS w=21.2u l=8.6u
X_FILL3_19_n GND VDD GND GND NMOS w=13.1u l=8.6u
X_FILL3_20_p VDD GND VDD VDD PMOS w=21.2u l=8.6u
X_FILL3_20_n GND VDD GND GND NMOS w=13.1u l=8.6u
X_FILL3_21_p VDD GND VDD VDD PMOS w=21.2u l=8.6u
X_FILL3_21_n GND VDD GND GND NMOS w=13.1u l=8.6u
X_FILL3_22_p VDD GND VDD VDD PMOS w=21.2u l=8.6u
X_FILL3_22_n GND VDD GND GND NMOS w=13.1u l=8.6u
X_FILL3_23_p VDD GND VDD VDD PMOS w=21.2u l=8.6u
X_FILL3_23_n GND VDD GND GND NMOS w=13.1u l=8.6u
X_FILL3_24_p VDD GND VDD VDD PMOS w=21.2u l=8.6u
X_FILL3_24_n GND VDD GND GND NMOS w=13.1u l=8.6u
X_FILL3_25_p VDD GND VDD VDD PMOS w=21.2u l=8.6u
X_FILL3_25_n GND VDD GND GND NMOS w=13.1u l=8.6u
X_FILL3_26_p VDD GND VDD VDD PMOS w=21.2u l=8.6u
X_FILL3_26_n GND VDD GND GND NMOS w=13.1u l=8.6u
X_FILL3_27_p VDD GND VDD VDD PMOS w=21.2u l=8.6u
X_FILL3_27_n GND VDD GND GND NMOS w=13.1u l=8.6u
X_FILL3_28_p VDD GND VDD VDD PMOS w=21.2u l=8.6u
X_FILL3_28_n GND VDD GND GND NMOS w=13.1u l=8.6u
X_FILL3_29_p VDD GND VDD VDD PMOS w=21.2u l=8.6u
X_FILL3_29_n GND VDD GND GND NMOS w=13.1u l=8.6u
X_FILL3_30_p VDD GND VDD VDD PMOS w=21.2u l=8.6u
X_FILL3_30_n GND VDD GND GND NMOS w=13.1u l=8.6u
X_FILL3_31_p VDD GND VDD VDD PMOS w=21.2u l=8.6u
X_FILL3_31_n GND VDD GND GND NMOS w=13.1u l=8.6u
X_FILL3_32_p VDD GND VDD VDD PMOS w=21.2u l=8.6u
X_FILL3_32_n GND VDD GND GND NMOS w=13.1u l=8.6u
X_FILL3_33_p VDD GND VDD VDD PMOS w=21.2u l=8.6u
X_FILL3_33_n GND VDD GND GND NMOS w=13.1u l=8.6u
X_FILL3_34_p VDD GND VDD VDD PMOS w=21.2u l=8.6u
X_FILL3_34_n GND VDD GND GND NMOS w=13.1u l=8.6u
X_FILL3_35_p VDD GND VDD VDD PMOS w=21.2u l=8.6u
X_FILL3_35_n GND VDD GND GND NMOS w=13.1u l=8.6u
X_FILL3_36_p VDD GND VDD VDD PMOS w=21.2u l=8.6u
X_FILL3_36_n GND VDD GND GND NMOS w=13.1u l=8.6u
X_FILL3_37_p VDD GND VDD VDD PMOS w=21.2u l=8.6u
X_FILL3_37_n GND VDD GND GND NMOS w=13.1u l=8.6u
X_FILL3_38_p VDD GND VDD VDD PMOS w=21.2u l=8.6u
X_FILL3_38_n GND VDD GND GND NMOS w=13.1u l=8.6u
X_FILL3_39_p VDD GND VDD VDD PMOS w=21.2u l=8.6u
X_FILL3_39_n GND VDD GND GND NMOS w=13.1u l=8.6u
X_FILL3_40_p VDD GND VDD VDD PMOS w=21.2u l=8.6u
X_FILL3_40_n GND VDD GND GND NMOS w=13.1u l=8.6u
X_FILL3_41_p VDD GND VDD VDD PMOS w=21.2u l=8.6u
X_FILL3_41_n GND VDD GND GND NMOS w=13.1u l=8.6u
X_FILL3_42_p VDD GND VDD VDD PMOS w=21.2u l=8.6u
X_FILL3_42_n GND VDD GND GND NMOS w=13.1u l=8.6u
X_FILL3_43_p VDD GND VDD VDD PMOS w=21.2u l=8.6u
X_FILL3_43_n GND VDD GND GND NMOS w=13.1u l=8.6u
X_FILL3_44_p VDD GND VDD VDD PMOS w=21.2u l=8.6u
X_FILL3_44_n GND VDD GND GND NMOS w=13.1u l=8.6u
X_FILL3_45_p VDD GND VDD VDD PMOS w=21.2u l=8.6u
X_FILL3_45_n GND VDD GND GND NMOS w=13.1u l=8.6u
X_FILL3_46_p VDD GND VDD VDD PMOS w=21.2u l=8.6u
X_FILL3_46_n GND VDD GND GND NMOS w=13.1u l=8.6u
X_FILL3_47_p VDD GND VDD VDD PMOS w=21.2u l=8.6u
X_FILL3_47_n GND VDD GND GND NMOS w=13.1u l=8.6u
X_FILL3_48_p VDD GND VDD VDD PMOS w=21.2u l=8.6u
X_FILL3_48_n GND VDD GND GND NMOS w=13.1u l=8.6u
.ends

.subckt AND2_X1 VDD Y A B GND
*.PININFO Y:O A:I B:I VDD:B GND:B
XM7 net1 B VDD VDD PMOS w=10.2u l=1u
XM1 net1 A VDD VDD PMOS w=10.2u l=1u
XM2 Y net1 VDD VDD PMOS w=10.2u l=1u
XM3 Y net1 GND GND NMOS w=3.4u l=1u
XM4 net1 A net2 GND NMOS w=3.4u l=1u
XM5 net2 B GND GND NMOS w=3.4u l=1u
.ends

.subckt BUFTH VDD A Y GND
*.PININFO A:I Y:O VDD:B GND:B
XM9 MID A net1 VDD PMOS w=5.1u l=1u
XM2 Y MID VDD VDD PMOS w=10.2u l=1u
XM8 MID A net2 GND NMOS w=3.4u l=1u
XM1 Y MID GND GND NMOS w=3.4u l=1u
XM6 GND MID net1 VDD PMOS w=10.2u l=1u
XM3 VDD MID net2 GND NMOS w=6.8u l=1u
XM5 net2 A GND GND NMOS w=3.4u l=1u
XM4 net1 A VDD VDD PMOS w=5.1u l=1u
.ends

.subckt BUF_X2 VDD A Y GND
XM7 net1 A VDD VDD PMOS w=10.2u l=1u
XM1 Y net1 VDD VDD PMOS w=10.2u l=1u m=2
XM3 net1 A GND GND NMOS w=3.4u l=1u
XM2 Y net1 GND GND NMOS w=3.4u l=1u m=2
.ends

.subckt DFFRB VDD QB D Q RSTB GND CK
*.PININFO VDD:B GND:B D:I QB:O CK:I Q:O RSTB:I
XM2 net1 D VDD VDD PMOS w=5.2u l=1u
XM1 net2 CKP net1 VDD PMOS w=5.2u l=1u
XM7 net2 CKB net3 GND NMOS w=3.4u l=1u
XM8 net3 D GND GND NMOS w=3.4u l=1u
XM10 QM net2 VDD VDD PMOS w=5.2u l=1u
XM11 QM net2 GND GND NMOS w=3.4u l=1u
XM13 net4 QM GND GND NMOS w=3.4u l=1u
XM15 net4 CKP net2 GND NMOS w=3.4u l=1u
XM22 QB QS VDD VDD PMOS w=10.4u l=1u
XM3 net4 QM VDD VDD PMOS w=5.2u l=1u
XM4 net2 CKB net4 VDD PMOS w=5.2u l=1u
XM5 QS CKP QM GND NMOS w=3.4u l=1u
XM6 QM CKB QS VDD PMOS w=5.2u l=1u
XM9 net5 QB GND GND NMOS w=3.4u l=1u
XM12 net5 QB VDD VDD PMOS w=5.2u l=1u
XM14 net5 CKB QS GND NMOS w=3.4u l=1u
XM16 QS CKP net5 VDD PMOS w=5.2u l=1u
XM17 QB RSTB net6 GND NMOS w=3.4u l=1u
XM18 Q QB VDD VDD PMOS w=10.4u l=1u
XM19 Q QB GND GND NMOS w=3.4u l=1u
XM20 CKB CK VDD VDD PMOS w=10.4u l=1u
XM21 CKB CK GND GND NMOS w=3.4u l=1u
XM23 CKP CKB VDD VDD PMOS w=10.4u l=1u
XM24 CKP CKB GND GND NMOS w=3.4u l=1u
XM25 net6 QS GND GND NMOS w=3.4u l=1u
XM26 QB RSTB VDD VDD PMOS w=10.4u l=1u
.ends

.subckt FILL2 VDD GND
*.PININFO GND:B VDD:B
XM7 VDD GND VDD VDD PMOS w=21.2u l=3.2u
XM2 GND VDD GND GND NMOS w=13.1u l=3.2u
.ends

.subckt INV_X1 VDD A Y GND
*.PININFO A:I Y:O GND:B VDD:B
XM7 Y A VDD VDD PMOS w=10.2u l=1u
XM2 Y A GND GND NMOS w=3.4u l=1u
.ends

.subckt MUX2 A B S VDD Y GND
*.PININFO S:I Y:O VDD:B GND:B B:I A:I
XM13 SB S VDD VDD PMOS w=6.8u l=1u
XM8 net2 S net3 VDD PMOS w=6.8u l=1u
XM12 SB S GND GND NMOS w=3.4u l=1u
XM6 net2 SB net3 GND NMOS w=3.4u l=1u
XM11 net1 B VDD VDD PMOS w=6.8u l=1u
XM14 net1 B GND GND NMOS w=3.4u l=1u
XM15 net2 A VDD VDD PMOS w=6.8u l=1u
XM16 net2 A GND GND NMOS w=3.4u l=1u
XM3 net1 SB net3 VDD PMOS w=6.8u l=1u
XM5 net1 S net3 GND NMOS w=3.4u l=1u
XM1 Y net3 VDD VDD PMOS w=11.2u l=1u
XM2 Y net3 GND GND NMOS w=3.4u l=1u
.ends

.subckt MUXDFFRB VDD A Q B CK S QB VSS RSTB
*.PININFO A:I B:I CK:I Q:O QB:O VDD:B VSS:B S:I RSTB:I
Xx1_MM2 x1_net1 net1 VDD VDD PMOS w=5.2u l=1u
Xx1_MM1 x1_net2 x1_CKP x1_net1 VDD PMOS w=5.2u l=1u
Xx1_MM7 x1_net2 x1_CKB x1_net3 VSS NMOS w=3.4u l=1u
Xx1_MM8 x1_net3 net1 VSS VSS NMOS w=3.4u l=1u
Xx1_MM10 x1_QM x1_net2 VDD VDD PMOS w=5.2u l=1u
Xx1_MM11 x1_QM x1_net2 VSS VSS NMOS w=3.4u l=1u
Xx1_MM13 x1_net4 x1_QM VSS VSS NMOS w=3.4u l=1u
Xx1_MM15 x1_net4 x1_CKP x1_net2 VSS NMOS w=3.4u l=1u
Xx1_MM22 QB x1_QS VDD VDD PMOS w=10.4u l=1u
Xx1_MM3 x1_net4 x1_QM VDD VDD PMOS w=5.2u l=1u
Xx1_MM4 x1_net2 x1_CKB x1_net4 VDD PMOS w=5.2u l=1u
Xx1_MM5 x1_QS x1_CKP x1_QM VSS NMOS w=3.4u l=1u
Xx1_MM6 x1_QM x1_CKB x1_QS VDD PMOS w=5.2u l=1u
Xx1_MM9 x1_net5 QB VSS VSS NMOS w=3.4u l=1u
Xx1_MM12 x1_net5 QB VDD VDD PMOS w=5.2u l=1u
Xx1_MM14 x1_net5 x1_CKB x1_QS VSS NMOS w=3.4u l=1u
Xx1_MM16 x1_QS x1_CKP x1_net5 VDD PMOS w=5.2u l=1u
Xx1_MM17 QB RSTB x1_net6 VSS NMOS w=3.4u l=1u
Xx1_MM18 Q QB VDD VDD PMOS w=10.4u l=1u
Xx1_MM19 Q QB VSS VSS NMOS w=3.4u l=1u
Xx1_MM20 x1_CKB CK VDD VDD PMOS w=10.4u l=1u
Xx1_MM21 x1_CKB CK VSS VSS NMOS w=3.4u l=1u
Xx1_MM23 x1_CKP x1_CKB VDD VDD PMOS w=10.4u l=1u
Xx1_MM24 x1_CKP x1_CKB VSS VSS NMOS w=3.4u l=1u
Xx1_MM25 x1_net6 x1_QS VSS VSS NMOS w=3.4u l=1u
Xx1_MM26 QB RSTB VDD VDD PMOS w=10.4u l=1u
Xx2_MM13 x2_SB S VDD VDD PMOS w=6.8u l=1u
Xx2_MM8 x2_net2 S x2_net3 VDD PMOS w=6.8u l=1u
Xx2_MM12 x2_SB S VSS VSS NMOS w=3.4u l=1u
Xx2_MM6 x2_net2 x2_SB x2_net3 VSS NMOS w=3.4u l=1u
Xx2_MM11 x2_net1 B VDD VDD PMOS w=6.8u l=1u
Xx2_MM14 x2_net1 B VSS VSS NMOS w=3.4u l=1u
Xx2_MM15 x2_net2 A VDD VDD PMOS w=6.8u l=1u
Xx2_MM16 x2_net2 A VSS VSS NMOS w=3.4u l=1u
Xx2_MM3 x2_net1 x2_SB x2_net3 VDD PMOS w=6.8u l=1u
Xx2_MM5 x2_net1 S x2_net3 VSS NMOS w=3.4u l=1u
Xx2_MM1 net1 x2_net3 VDD VDD PMOS w=11.2u l=1u
Xx2_MM2 net1 x2_net3 VSS VSS NMOS w=3.4u l=1u
.ends

.subckt NAND2 VDD Y A B GND
*.PININFO B:I A:I Y:O GND:B VDD:B
XM7 Y A VDD VDD PMOS w=10.2u l=1u
XM1 Y B VDD VDD PMOS w=10.2u l=1u
XM2 Y B net1 GND NMOS w=3.4u l=1u
XM3 net1 A GND GND NMOS w=3.4u l=1u
.ends

.subckt NOR4 A B C D VDD Y GND
*.PININFO A:I B:I Y:O VDD:B GND:B C:I D:I
XM8 net1 B VDD VDD PMOS w=10.2u l=1u
XM2 net2 A net1 VDD PMOS w=10.2u l=1u
XM3 net3 C net2 VDD PMOS w=10.2u l=1u
XM6 Y D net3 VDD PMOS w=10.2u l=1u
XM9 Y D GND GND NMOS w=3.4u l=1u
XM1 Y B GND GND NMOS w=3.4u l=1u
XM4 Y C GND GND NMOS w=3.4u l=1u
XM5 Y A GND GND NMOS w=3.4u l=1u
.ends

.subckt OR3 C VDD Y A B GND
*.PININFO A:I B:I Y:O VDD:B GND:B C:I
XM8 net1 B VDD VDD PMOS w=10.2u l=1u
XM2 net2 A net1 VDD PMOS w=10.2u l=1u
XM3 net3 C net2 VDD PMOS w=10.2u l=1u
XM7 Y net3 VDD VDD PMOS w=10.2u l=1u
XM9 Y net3 GND GND NMOS w=3.4u l=1u
XM1 net3 C GND GND NMOS w=3.4u l=1u
XM4 net3 A GND GND NMOS w=3.4u l=1u
XM5 net3 B GND GND NMOS w=3.4u l=1u
.ends

.subckt XNOR2 VDD Y A B GND
*.PININFO VDD:B GND:B A:I B:I Y:O
XM10 net1 A VDD VDD PMOS w=10.2u l=1u
XM1 net1 B VDD VDD PMOS w=10.2u l=1u
XM2 Y net1 VDD VDD PMOS w=10.2u l=1u
XM3 net4 B VDD VDD PMOS w=10.2u l=1u
XM4 Y A net4 VDD PMOS w=10.2u l=1u
XM11 net1 B net3 GND NMOS w=3.4u l=1u
XM5 net3 A GND GND NMOS w=3.4u l=1u
XM6 Y net1 net2 GND NMOS w=3.4u l=1u
XM7 net2 A GND GND NMOS w=3.4u l=1u
XM8 net2 B GND GND NMOS w=3.4u l=1u
.ends

.subckt XOR2 VDD Y A B GND
*.PININFO VDD:B GND:B A:I B:I Y:O
XM10 net1 A VDD VDD PMOS w=10.2u l=1u
XM1 net2 B net1 VDD PMOS w=10.2u l=1u
XM8 net3 A VDD VDD PMOS w=10.2u l=1u
XM2 net3 B VDD VDD PMOS w=10.2u l=1u
XM9 Y net2 net3 VDD PMOS w=10.2u l=1u
XM3 net2 A GND GND NMOS w=3.4u l=1u
XM4 net2 B GND GND NMOS w=3.4u l=1u
XM5 Y net2 GND GND NMOS w=3.4u l=1u
XM7 net4 B GND GND NMOS w=3.4u l=1u
XM6 Y A net4 GND NMOS w=3.4u l=1u
.ends

.subckt tr_1um_3wire_SPI P1 P2 P3 P4 P5 P6 P7 VSS P9 P10 P11 P12 P13 P14 P15 VDD
x1 P1 VDD P2 P15 P14 P3 P4 P13
+ P5 P12 P6 P11 P10 P7 P9 VSS
+ VDD sdio_oe_n P5 P5 VDD VSS P5 VDD
+ P5 P5 P5 P5 P5 VDD VSS sdio_out
+ rx_data_2 rx_data_3 VSS byte_end rx_data_4 VSS rx_data_5 rx_data_0
+ rx_data_6 rx_data_7 rx_data_1 VSS OSS_FRAME_GIO
x2 P15 P1 P3 P5 P2 sdio_out sdio_oe_n P6
+ P7 P9 P10 P11 P12 P13 P14 rx_data_0
+ rx_data_1 rx_data_2 rx_data_3 rx_data_4 rx_data_5 rx_data_6 rx_data_7 NC_CORE_data_oe
+ byte_end VDD VSS spi_slave_sclk_nrow_fm
.ends
