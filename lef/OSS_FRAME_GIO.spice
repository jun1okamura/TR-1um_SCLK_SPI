** sch_path: /Users/okamura/Dropbox/91_OpenPDK/TR-1um/libs.tech/xschem/TR-1um_frame/OSS_FRAME_GIO.sch
.subckt OSS_FRAME_GIO P1 VDD P2 P15 P14 P3 P4 P13 P5 P12 P6 P11 P10 P7 P9 VSS HIZ1 HIZ2 HIZ9 HIZ10 HIZ3 HIZ4 HIZ11 HIZ5 HIZ12 HIZ6
+ HIZ13 HIZ14 HIZ7 HIZ15 OUT1 OUT2 OUT9 OUT10 OUT3 OUT4 OUT11 OUT5 OUT12 OUT6 OUT13 OUT14 OUT7 OUT15
*.PININFO P1:B P2:B P3:B P4:B P5:B P6:B P7:B VSS:B VDD:B P15:B P14:B P13:B P12:B P11:B P10:B P9:B HIZ1:I OUT1:I HIZ2:I OUT2:I
*+ HIZ3:I OUT3:I HIZ4:I OUT4:I HIZ5:I OUT5:I HIZ6:I OUT6:I HIZ7:I OUT7:I HIZ15:I OUT15:I HIZ14:I OUT14:I HIZ13:I OUT13:I HIZ12:I OUT12:I
*+ HIZ11:I OUT11:I HIZ10:I OUT10:I HIZ9:I OUT9:I
x1 VDD P1 VSS HIZ1 OUT1 OSS_ESD_5V_DIO
x2 VDD VSS OSS_ESD_5V_VDD
x3 VDD VSS OSS_ESD_5V_VSS
x4 VDD P2 VSS HIZ2 OUT2 OSS_ESD_5V_DIO
x5 VDD P3 VSS HIZ3 OUT3 OSS_ESD_5V_DIO
x6 VDD P4 VSS HIZ4 OUT4 OSS_ESD_5V_DIO
x7 VDD P5 VSS HIZ5 OUT5 OSS_ESD_5V_DIO
x8 VDD P6 VSS HIZ6 OUT6 OSS_ESD_5V_DIO
x9 VDD P7 VSS HIZ7 OUT7 OSS_ESD_5V_DIO
x10 VDD P15 VSS HIZ15 OUT15 OSS_ESD_5V_DIO
x11 VDD P14 VSS HIZ14 OUT14 OSS_ESD_5V_DIO
x12 VDD P13 VSS HIZ13 OUT13 OSS_ESD_5V_DIO
x13 VDD P12 VSS HIZ12 OUT12 OSS_ESD_5V_DIO
x14 VDD P11 VSS HIZ11 OUT11 OSS_ESD_5V_DIO
x15 VDD P10 VSS HIZ10 OUT10 OSS_ESD_5V_DIO
x16 VDD P9 VSS HIZ9 OUT9 OSS_ESD_5V_DIO
.ends

* expanding   symbol:  OSS_ESD_5V_DIO.sym # of pins=6
** sym_path: /Users/okamura/Dropbox/91_OpenPDK/TR-1um/libs.tech/xschem/TR-1um_frame/OSS_ESD_5V_DIO.sym
** sch_path: /Users/okamura/Dropbox/91_OpenPDK/TR-1um/libs.tech/xschem/TR-1um_frame/OSS_ESD_5V_DIO.sch
.subckt OSS_ESD_5V_DIO VDD PAD VSS HIZ OUT
*.PININFO PAD:B VDD:B VSS:B HIZ:I OUT:I
MXM1 PAD PG VDD VDD PMOS w=300u l=2u
MXM2 PAD NG VSS VSS NMOSE w=150u l=2u
MXM3 PG PGG VDD VDD PMOS w=20.8u l=1u
MXM4 PG PGG VSS VSS NMOS w=6.8u l=1u
MXM5 PAD VDD VDD VDD PMOS w=200u l=2u
MXM6 PAD VSS VSS VSS NMOSE w=350u l=2u
MXM7 NG NGG VDD VDD PMOS w=20.8u l=1u
MXM8 NG NGG VSS VSS NMOS w=6.8u l=1u
MXM9 PGG HIZ net2 VDD PMOS w=10.4u l=1u
MXM10 net2 net1 VDD VDD PMOS w=10.4u l=1u
MXM11 PGG net1 VSS VSS NMOS w=3.4u l=1u
MXM12 PGG HIZ VSS VSS NMOS w=3.4u l=1u
MXM13 NGG net1 VDD VDD PMOS w=5.2u l=1u
MXM14 NGG ENB VDD VDD PMOS w=5.2u l=1u
MXM15 NGG ENB net3 VSS NMOS w=3.4u l=1u
MXM16 net3 net1 VSS VSS NMOS w=3.4u l=1u
MXM17 ENB HIZ VDD VDD PMOS w=5.2u l=1u
MXM18 ENB HIZ VSS VSS NMOS w=3.4u l=1u
DD1 VSS HIZ DN A=12.96p P=14.4u
MXM19 net1 OUT VDD VDD PMOS w=5.2u l=1u
MXM20 net1 OUT VSS VSS NMOS w=3.4u l=1u
DD2 VSS OUT DN A=12.96p P=14.4u
.ends

* expanding   symbol:  OSS_ESD_5V_VDD.sym # of pins=3
** sym_path: /Users/okamura/Dropbox/91_OpenPDK/TR-1um/libs.tech/xschem/TR-1um_frame/OSS_ESD_5V_VDD.sym
** sch_path: /Users/okamura/Dropbox/91_OpenPDK/TR-1um/libs.tech/xschem/TR-1um_frame/OSS_ESD_5V_VDD.sch
.subckt OSS_ESD_5V_VDD VDD VSS
*.PININFO VSS:B VDD:B VDD:B
MXM5 VSS VDD VDD VDD PMOS w=500u l=2u
MXM6 VDD VSS VSS VSS NMOSE w=500u l=2u
.ends

* expanding   symbol:  OSS_ESD_5V_VSS.sym # of pins=3
** sym_path: /Users/okamura/Dropbox/91_OpenPDK/TR-1um/libs.tech/xschem/TR-1um_frame/OSS_ESD_5V_VSS.sym
** sch_path: /Users/okamura/Dropbox/91_OpenPDK/TR-1um/libs.tech/xschem/TR-1um_frame/OSS_ESD_5V_VSS.sch
.subckt OSS_ESD_5V_VSS VDD VSS
*.PININFO VSS:B VDD:B VSS:B
MXM3 VSS VDD VDD VDD PMOS w=500u l=2u
MXM4 VDD VSS VSS VSS NMOSE w=500u l=2u
.ends
