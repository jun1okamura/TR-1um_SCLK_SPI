* tb_chip_spi.spice -- chip-level ngspice testbench for tr_1um_3wire_SPI.
* GENERATED by scripts/gen_chip_tb.py; do not edit by hand.
* Companion checker: scripts/check_chip_sim.py, using
* ngspice/tb_chip_spi_expected.json written by the same run.
*
*   WRITE 0xA5 (DIS=0) -> READ 0x3D (DIS=1) -> WRITE 0x5A
*   SCLK 1 MHz, Mode 0, MSB first, 37.5 us total
*
.include '~/Dropbox/91_OpenPDK/TR-1um/libs.tech/spice/models/ip62_models'
.include 'tr_1um_3wire_SPI_sim_ready.spice'

vvdd VDD 0 DC 5.0
vvss VSS 0 DC 0

vrstn P15 0 PWL(0 0.000 4.8e-07 0.000 5e-07 5.000 3.75e-05 5.000)
vcs P3 0 PWL(0 5.000 4.98e-06 5.000 5e-06 0.000 1.348e-05 0.000 1.35e-05 5.000 1.598e-05 5.000 1.6e-05 0.000 2.448e-05 0.000 2.45e-05 5.000 2.748e-05 5.000 2.75e-05 0.000 3.598e-05 0.000 3.6e-05 5.000 3.75e-05 5.000)
vdis P5 0 PWL(0 0.000 1.398e-05 0.000 1.4e-05 5.000 2.548e-05 5.000 2.55e-05 0.000 3.75e-05 0.000)
vsclk P1 0 PWL(0 0.000 5.48e-06 0.000 5.5e-06 5.000 5.98e-06 5.000 6e-06 0.000 6.48e-06 0.000 6.5e-06 5.000 6.98e-06 5.000 7e-06 0.000 7.48e-06 0.000 7.5e-06 5.000 7.98e-06 5.000 8e-06 0.000 8.48e-06 0.000 8.5e-06 5.000 8.98e-06 5.000 9e-06 0.000 9.48e-06 0.000 9.5e-06 5.000 9.98e-06 5.000 1e-05 0.000 1.048e-05 0.000 1.05e-05 5.000 1.098e-05 5.000 1.1e-05 0.000 1.148e-05 0.000 1.15e-05 5.000 1.198e-05 5.000 1.2e-05 0.000 1.248e-05 0.000 1.25e-05 5.000 1.298e-05 5.000 1.3e-05 0.000 1.648e-05 0.000 1.65e-05 5.000 1.698e-05 5.000 1.7e-05 0.000 1.748e-05 0.000 1.75e-05 5.000 1.798e-05 5.000 1.8e-05 0.000 1.848e-05 0.000 1.85e-05 5.000 1.898e-05 5.000 1.9e-05 0.000 1.948e-05 0.000 1.95e-05 5.000 1.998e-05 5.000 2e-05 0.000 2.048e-05 0.000 2.05e-05 5.000 2.098e-05 5.000 2.1e-05 0.000 2.148e-05 0.000 2.15e-05 5.000 2.198e-05 5.000 2.2e-05 0.000 2.248e-05 0.000 2.25e-05 5.000 2.298e-05 5.000 2.3e-05 0.000 2.348e-05 0.000 2.35e-05 5.000 2.398e-05 5.000 2.4e-05 0.000 2.798e-05 0.000 2.8e-05 5.000 2.848e-05 5.000 2.85e-05 0.000 2.898e-05 0.000 2.9e-05 5.000 2.948e-05 5.000 2.95e-05 0.000 2.998e-05 0.000 3e-05 5.000 3.048e-05 5.000 3.05e-05 0.000 3.098e-05 0.000 3.1e-05 5.000 3.148e-05 5.000 3.15e-05 0.000 3.198e-05 0.000 3.2e-05 5.000 3.248e-05 5.000 3.25e-05 0.000 3.298e-05 0.000 3.3e-05 5.000 3.348e-05 5.000 3.35e-05 0.000 3.398e-05 0.000 3.4e-05 5.000 3.448e-05 5.000 3.45e-05 0.000 3.498e-05 0.000 3.5e-05 5.000 3.548e-05 5.000 3.55e-05 0.000 3.75e-05 0.000)

* Only one side ever drives a bidirectional pad.  TXGATE mirrors DIS, so
* the bench's tx_data drives are open exactly while the chip owns the
* DATA pads; MGATE is high only during the WRITE frames.
.model TXSW SW(RON=10 ROFF=1T VT=2.5 VH=0.3)
vtxgate TXGATE 0 PWL(0 0.000 1.398e-05 0.000 1.4e-05 5.000 2.548e-05 5.000 2.55e-05 0.000 3.75e-05 0.000)
vmgate MGATE 0 PWL(0 5.000 1.398e-05 5.000 1.4e-05 0.000 2.548e-05 0.000 2.55e-05 5.000 3.75e-05 5.000)

vtx0 vtx0n 0 DC 5.0   $ tx_data[0] of 0x3D
stx0 vtx0n vtx0s TXGATE 0 TXSW
rtx0 vtx0s P6 10k
rpd0 P6 VSS 1MEG   $ DC path + Hi-Z level; 1% of a logic level
vtx1 vtx1n 0 DC 0.0   $ tx_data[1] of 0x3D
stx1 vtx1n vtx1s TXGATE 0 TXSW
rtx1 vtx1s P7 10k
rpd1 P7 VSS 1MEG   $ DC path + Hi-Z level; 1% of a logic level
vtx2 vtx2n 0 DC 5.0   $ tx_data[2] of 0x3D
stx2 vtx2n vtx2s TXGATE 0 TXSW
rtx2 vtx2s P9 10k
rpd2 P9 VSS 1MEG   $ DC path + Hi-Z level; 1% of a logic level
vtx3 vtx3n 0 DC 5.0   $ tx_data[3] of 0x3D
stx3 vtx3n vtx3s TXGATE 0 TXSW
rtx3 vtx3s P10 10k
rpd3 P10 VSS 1MEG   $ DC path + Hi-Z level; 1% of a logic level
vtx4 vtx4n 0 DC 5.0   $ tx_data[4] of 0x3D
stx4 vtx4n vtx4s TXGATE 0 TXSW
rtx4 vtx4s P11 10k
rpd4 P11 VSS 1MEG   $ DC path + Hi-Z level; 1% of a logic level
vtx5 vtx5n 0 DC 5.0   $ tx_data[5] of 0x3D
stx5 vtx5n vtx5s TXGATE 0 TXSW
rtx5 vtx5s P12 10k
rpd5 P12 VSS 1MEG   $ DC path + Hi-Z level; 1% of a logic level
vtx6 vtx6n 0 DC 0.0   $ tx_data[6] of 0x3D
stx6 vtx6n vtx6s TXGATE 0 TXSW
rtx6 vtx6s P13 10k
rpd6 P13 VSS 1MEG   $ DC path + Hi-Z level; 1% of a logic level
vtx7 vtx7n 0 DC 0.0   $ tx_data[7] of 0x3D
stx7 vtx7n vtx7s TXGATE 0 TXSW
rtx7 vtx7s P14 10k
rpd7 P14 VSS 1MEG   $ DC path + Hi-Z level; 1% of a logic level

vsdio SDIO_M 0 PWL(0 0.000 4.48e-06 0.000 4.5e-06 5.000 5.98e-06 5.000 6e-06 0.000 6.98e-06 0.000 7e-06 5.000 7.98e-06 5.000 8e-06 0.000 9.98e-06 0.000 1e-05 5.000 1.098e-05 5.000 1.1e-05 0.000 1.198e-05 0.000 1.2e-05 5.000 2.698e-05 5.000 2.7e-05 0.000 2.848e-05 0.000 2.85e-05 5.000 2.948e-05 5.000 2.95e-05 0.000 3.048e-05 0.000 3.05e-05 5.000 3.248e-05 5.000 3.25e-05 0.000 3.348e-05 0.000 3.35e-05 5.000 3.448e-05 5.000 3.45e-05 0.000 3.75e-05 0.000)
ssdio SDIO_M SDIO_S MGATE 0 TXSW
rsdio SDIO_S P2 1k
rsdio_pd P2 VSS 20k   $ pulls SDIO to 0 the moment a driver lets go

xdut P1 P2 P3 P4 P5 P6 P7 VSS P9 P10 P11 P12 P13 P14 P15 VDD tr_1um_3wire_SPI

* Tmax = 1ns (4th argument).  See this file's generator for why anything
* coarser is not trustworthy on this design.
.tran 50n 3.75e-05 0 1n

* ---- checks ----
.measure tran rx_reset_bit0 FIND v(P6) AT=4.5e-06  $ DATA pads read 0x00 out of reset -- bit0
.measure tran rx_reset_bit1 FIND v(P7) AT=4.5e-06  $ DATA pads read 0x00 out of reset -- bit1
.measure tran rx_reset_bit2 FIND v(P9) AT=4.5e-06  $ DATA pads read 0x00 out of reset -- bit2
.measure tran rx_reset_bit3 FIND v(P10) AT=4.5e-06  $ DATA pads read 0x00 out of reset -- bit3
.measure tran rx_reset_bit4 FIND v(P11) AT=4.5e-06  $ DATA pads read 0x00 out of reset -- bit4
.measure tran rx_reset_bit5 FIND v(P12) AT=4.5e-06  $ DATA pads read 0x00 out of reset -- bit5
.measure tran rx_reset_bit6 FIND v(P13) AT=4.5e-06  $ DATA pads read 0x00 out of reset -- bit6
.measure tran rx_reset_bit7 FIND v(P14) AT=4.5e-06  $ DATA pads read 0x00 out of reset -- bit7
.measure tran test_idle FIND v(P4) AT=4.5e-06  $ byte_end low while CS is high
.measure tran test_mid_wr1 FIND v(P4) AT=8e-06  $ byte_end low mid-frame (bit 3 of the WRITE)
.measure tran test_last_wr1 FIND v(P4) AT=1.2e-05  $ byte_end high during the 8th bit of the WRITE
.measure tran rx_wr1_bit0 FIND v(P6) AT=1.32e-05  $ DATA pads carry the received 0xA5 -- bit0
.measure tran rx_wr1_bit1 FIND v(P7) AT=1.32e-05  $ DATA pads carry the received 0xA5 -- bit1
.measure tran rx_wr1_bit2 FIND v(P9) AT=1.32e-05  $ DATA pads carry the received 0xA5 -- bit2
.measure tran rx_wr1_bit3 FIND v(P10) AT=1.32e-05  $ DATA pads carry the received 0xA5 -- bit3
.measure tran rx_wr1_bit4 FIND v(P11) AT=1.32e-05  $ DATA pads carry the received 0xA5 -- bit4
.measure tran rx_wr1_bit5 FIND v(P12) AT=1.32e-05  $ DATA pads carry the received 0xA5 -- bit5
.measure tran rx_wr1_bit6 FIND v(P13) AT=1.32e-05  $ DATA pads carry the received 0xA5 -- bit6
.measure tran rx_wr1_bit7 FIND v(P14) AT=1.32e-05  $ DATA pads carry the received 0xA5 -- bit7
.measure tran sdio_hiz_idle FIND v(P2) AT=1.57e-05  $ SDIO high-Z with DIS=1 and CS high
.measure tran tx_pads_bit0 FIND v(P6) AT=1.57e-05  $ DATA pads are inputs carrying tx_data = 0x3D -- bit0
.measure tran tx_pads_bit1 FIND v(P7) AT=1.57e-05  $ DATA pads are inputs carrying tx_data = 0x3D -- bit1
.measure tran tx_pads_bit2 FIND v(P9) AT=1.57e-05  $ DATA pads are inputs carrying tx_data = 0x3D -- bit2
.measure tran tx_pads_bit3 FIND v(P10) AT=1.57e-05  $ DATA pads are inputs carrying tx_data = 0x3D -- bit3
.measure tran tx_pads_bit4 FIND v(P11) AT=1.57e-05  $ DATA pads are inputs carrying tx_data = 0x3D -- bit4
.measure tran tx_pads_bit5 FIND v(P12) AT=1.57e-05  $ DATA pads are inputs carrying tx_data = 0x3D -- bit5
.measure tran tx_pads_bit6 FIND v(P13) AT=1.57e-05  $ DATA pads are inputs carrying tx_data = 0x3D -- bit6
.measure tran tx_pads_bit7 FIND v(P14) AT=1.57e-05  $ DATA pads are inputs carrying tx_data = 0x3D -- bit7
.measure tran read_byte_bit0 FIND v(P2) AT=2.35e-05  $ the chip shifted 0x3D out on SDIO -- bit0
.measure tran read_byte_bit1 FIND v(P2) AT=2.25e-05  $ the chip shifted 0x3D out on SDIO -- bit1
.measure tran read_byte_bit2 FIND v(P2) AT=2.15e-05  $ the chip shifted 0x3D out on SDIO -- bit2
.measure tran read_byte_bit3 FIND v(P2) AT=2.05e-05  $ the chip shifted 0x3D out on SDIO -- bit3
.measure tran read_byte_bit4 FIND v(P2) AT=1.95e-05  $ the chip shifted 0x3D out on SDIO -- bit4
.measure tran read_byte_bit5 FIND v(P2) AT=1.85e-05  $ the chip shifted 0x3D out on SDIO -- bit5
.measure tran read_byte_bit6 FIND v(P2) AT=1.75e-05  $ the chip shifted 0x3D out on SDIO -- bit6
.measure tran read_byte_bit7 FIND v(P2) AT=1.65e-05  $ the chip shifted 0x3D out on SDIO -- bit7
.measure tran test_last_rd FIND v(P4) AT=2.3e-05  $ byte_end high during the 8th bit of the READ
.measure tran sdio_hiz_after_read FIND v(P2) AT=2.52e-05  $ SDIO released after CS rises (last bit driven was 1)
.measure tran rx_kept_bit0 FIND v(P6) AT=2.72e-05  $ the READ frame left rx_data at 0xA5 -- bit0
.measure tran rx_kept_bit1 FIND v(P7) AT=2.72e-05  $ the READ frame left rx_data at 0xA5 -- bit1
.measure tran rx_kept_bit2 FIND v(P9) AT=2.72e-05  $ the READ frame left rx_data at 0xA5 -- bit2
.measure tran rx_kept_bit3 FIND v(P10) AT=2.72e-05  $ the READ frame left rx_data at 0xA5 -- bit3
.measure tran rx_kept_bit4 FIND v(P11) AT=2.72e-05  $ the READ frame left rx_data at 0xA5 -- bit4
.measure tran rx_kept_bit5 FIND v(P12) AT=2.72e-05  $ the READ frame left rx_data at 0xA5 -- bit5
.measure tran rx_kept_bit6 FIND v(P13) AT=2.72e-05  $ the READ frame left rx_data at 0xA5 -- bit6
.measure tran rx_kept_bit7 FIND v(P14) AT=2.72e-05  $ the READ frame left rx_data at 0xA5 -- bit7
.measure tran rx_wr2_bit0 FIND v(P6) AT=3.57e-05  $ a second WRITE frame lands 0x5A -- bit0
.measure tran rx_wr2_bit1 FIND v(P7) AT=3.57e-05  $ a second WRITE frame lands 0x5A -- bit1
.measure tran rx_wr2_bit2 FIND v(P9) AT=3.57e-05  $ a second WRITE frame lands 0x5A -- bit2
.measure tran rx_wr2_bit3 FIND v(P10) AT=3.57e-05  $ a second WRITE frame lands 0x5A -- bit3
.measure tran rx_wr2_bit4 FIND v(P11) AT=3.57e-05  $ a second WRITE frame lands 0x5A -- bit4
.measure tran rx_wr2_bit5 FIND v(P12) AT=3.57e-05  $ a second WRITE frame lands 0x5A -- bit5
.measure tran rx_wr2_bit6 FIND v(P13) AT=3.57e-05  $ a second WRITE frame lands 0x5A -- bit6
.measure tran rx_wr2_bit7 FIND v(P14) AT=3.57e-05  $ a second WRITE frame lands 0x5A -- bit7

* The control block exists only to hold `save`, which keeps the output
* vectors down to the sixteen pads instead of every node in the chip.
* Deliberately NO `run` and no `print`: in batch mode ngspice runs the
* .tran card itself, so a `run` here makes it run the whole analysis a
* SECOND time and print a second, identical measurement block -- twice
* the wall clock for nothing.  (The I2C bench carried that `run`; both
* of its passes agreed to the last digit, which is how we know it was
* redundant rather than wrong.)  ngspice auto-prints every .measure
* result once, and that block is the sole thing the checker parses.
.control
  save v(P1) v(P2) v(P3) v(P4) v(P5) v(P6) v(P7) v(P9) v(P10) v(P11) v(P12) v(P13) v(P14) v(P15)
.endc

.end
