* OSS_FRAME_GIO — LVS ソースネットリスト（フレーム）
*
* scripts/mkframespice.py が生成。手で編集しないこと。
* 出どころ: TR-1um_frame_25x25_GIO.gds を KLayout のエンジンで抽出し凍結した。
*   フレームは PDK 提供で回路図が無いので、**この .spice に対する LVS は
*   「レイアウト vs そのレイアウトから作った網」であり、それ自体は何も
*   証明しない**。チップ全体の LVS での回帰検査用。
*
* 層の導出は PDK のランセット（00_Layers.drc / 02_Device.drc /
* tech/lvs/01_Extract.lvs）に合わせてある。ESD 認識層 (63,2) の中の
* NMOS は NMOSE、ゲートを持たない拡散はダイオード DN/DP として扱う。
*
* 書き出したあと scripts/lvs_check.py で抽出網と照合して一致を確認済み
* （ネットやピンを取り違えていないことの確認。レイアウトの正しさの証明ではない）。
*
* OSS_ESD_5V_DIO の動作（ngspice で確認）:
*   HIZ=0 -> PAD = OUT（非反転バッファ。CL=10pF で立上り 10.4ns / 立下り 9.8ns）
*   HIZ=1 -> PAD は高インピーダンス（10uA を注いだら素直に電位が動いた）
*   => 双方向 IO。読むときは HIZ=1 にして PAD をコアの入力に直結する
*      （入力バッファは入っていないので受け側は自前）。
*   出力段: PMOS W=300u / NMOS W=150u（L=2u）。
*   これとは別に、ゲートを電源に固定した ESD 素子
*   （PMOS W=200u gate=VDD / NMOSE W=350u gate=VSS）が並んでいる。
*

.subckt OSS_NCH_DRV PAD G VSS
M1 VSS VSS PAD VSS NMOSE W=50u L=2u
M2 PAD VSS VSS VSS NMOSE W=50u L=2u
M3 VSS VSS PAD VSS NMOSE W=50u L=2u
M4 PAD VSS VSS VSS NMOSE W=50u L=2u
M5 VSS VSS PAD VSS NMOSE W=50u L=2u
M6 PAD VSS VSS VSS NMOSE W=50u L=2u
M7 VSS VSS PAD VSS NMOSE W=50u L=2u
M8 PAD G VSS VSS NMOSE W=50u L=2u
M9 VSS G PAD VSS NMOSE W=50u L=2u
M10 PAD G VSS VSS NMOSE W=50u L=2u
.ends OSS_NCH_DRV

.subckt OSS_PCH_DRV PAD VDD G
M1 VDD VDD PAD VDD PMOS W=50u L=2u
M2 PAD VDD VDD VDD PMOS W=50u L=2u
M3 VDD VDD PAD VDD PMOS W=50u L=2u
M4 PAD VDD VDD VDD PMOS W=50u L=2u
M5 VDD G PAD VDD PMOS W=50u L=2u
M6 PAD G VDD VDD PMOS W=50u L=2u
M7 VDD G PAD VDD PMOS W=50u L=2u
M8 PAD G VDD VDD PMOS W=50u L=2u
M9 VDD G PAD VDD PMOS W=50u L=2u
M10 PAD G VDD VDD PMOS W=50u L=2u
.ends OSS_PCH_DRV

.subckt diode_n A VSS
D1 VSS A DN A=12.96p P=14.4u
.ends diode_n

.subckt OSS_DRV OUT HIZ vdd GP GN GND
X7 OUT GND diode_n
X11 HIZ GND diode_n
M1 GN n4 vdd vdd PMOS W=14.2u L=1u
M2 vdd OUT n2 vdd PMOS W=5.2u L=1u
M3 vdd HIZ n1 vdd PMOS W=5.2u L=1u
M4 n4 n1 vdd vdd PMOS W=5.2u L=1u
M5 vdd n2 n4 vdd PMOS W=5.2u L=1u
M6 GN n4 vdd vdd PMOS W=5.2u L=1u
M7 n5 HIZ n3 vdd PMOS W=10.4u L=1u
M8 vdd n2 n5 vdd PMOS W=10.4u L=1u
M9 GP n3 vdd vdd PMOS W=10.4u L=1u
M10 GP n3 vdd vdd PMOS W=10.4u L=1u
M11 n6 n1 n4 GND NMOS W=3.4u L=1u
M12 GND n2 n6 GND NMOS W=3.4u L=1u
M13 GN n4 GND GND NMOS W=3.4u L=1u
M14 GN n4 GND GND NMOS W=3.4u L=1u
M15 GP n3 GND GND NMOS W=3.4u L=1u
M16 GND OUT n2 GND NMOS W=3.4u L=1u
M17 n3 HIZ GND GND NMOS W=3.4u L=1u
M18 GND n2 n3 GND NMOS W=3.4u L=1u
M19 GP n3 GND GND NMOS W=3.4u L=1u
M20 GND HIZ n1 GND NMOS W=3.4u L=1u
.ends OSS_DRV

.subckt OSS_ESD_5V_DIO PAD VDD HIZ OUT VSS
X1 PAD n2 VSS OSS_NCH_DRV
X2 PAD VDD n1 OSS_PCH_DRV
X5 OUT HIZ VDD n1 n2 VSS OSS_DRV
.ends OSS_ESD_5V_DIO

.subckt OSS_NCH_ESD PAD VSS
M1 VSS VSS PAD VSS NMOSE W=50u L=2u
M2 PAD VSS VSS VSS NMOSE W=50u L=2u
M3 VSS VSS PAD VSS NMOSE W=50u L=2u
M4 PAD VSS VSS VSS NMOSE W=50u L=2u
M5 VSS VSS PAD VSS NMOSE W=50u L=2u
M6 PAD VSS VSS VSS NMOSE W=50u L=2u
M7 VSS VSS PAD VSS NMOSE W=50u L=2u
M8 PAD VSS VSS VSS NMOSE W=50u L=2u
M9 VSS VSS PAD VSS NMOSE W=50u L=2u
M10 PAD VSS VSS VSS NMOSE W=50u L=2u
.ends OSS_NCH_ESD

.subckt OSS_PCH_ESD PAD VDD
M1 VDD VDD PAD VDD PMOS W=50u L=2u
M2 PAD VDD VDD VDD PMOS W=50u L=2u
M3 VDD VDD PAD VDD PMOS W=50u L=2u
M4 PAD VDD VDD VDD PMOS W=50u L=2u
M5 VDD VDD PAD VDD PMOS W=50u L=2u
M6 PAD VDD VDD VDD PMOS W=50u L=2u
M7 VDD VDD PAD VDD PMOS W=50u L=2u
M8 PAD VDD VDD VDD PMOS W=50u L=2u
M9 VDD VDD PAD VDD PMOS W=50u L=2u
M10 PAD VDD VDD VDD PMOS W=50u L=2u
.ends OSS_PCH_ESD

.subckt OSS_ESD_5V_VSS VDD VSS
X1 VDD VSS OSS_NCH_ESD
X2 VSS VDD OSS_PCH_ESD
.ends OSS_ESD_5V_VSS

.subckt OSS_ESD_5V_VDD VDD VSS
X1 VDD VSS OSS_NCH_ESD
X3 VSS VDD OSS_PCH_ESD
.ends OSS_ESD_5V_VDD

.subckt OSS_FRAME_GIO HIZ1 HIZ10 HIZ11 HIZ12 HIZ13 HIZ14 HIZ15 HIZ2 HIZ3 HIZ4 HIZ5 HIZ6 HIZ7 HIZ9 OUT1 OUT10 OUT11 OUT12 OUT13 OUT14 OUT15 OUT2 OUT3 OUT4 OUT5 OUT6 OUT7 OUT9 P1 P10 P11 P12 P13 P14 P15 P2 P3 P4 P5 P6 P7 P9 VDD VSS
X4 P6 VDD HIZ6 OUT6 VSS OSS_ESD_5V_DIO
X5 P4 VDD HIZ4 OUT4 VSS OSS_ESD_5V_DIO
X6 P5 VDD HIZ5 OUT5 VSS OSS_ESD_5V_DIO
X7 P9 VDD HIZ9 OUT9 VSS OSS_ESD_5V_DIO
X8 P7 VDD HIZ7 OUT7 VSS OSS_ESD_5V_DIO
X9 VDD VSS OSS_ESD_5V_VSS
X10 P10 VDD HIZ10 OUT10 VSS OSS_ESD_5V_DIO
X11 P14 VDD HIZ14 OUT14 VSS OSS_ESD_5V_DIO
X12 P12 VDD HIZ12 OUT12 VSS OSS_ESD_5V_DIO
X13 P11 VDD HIZ11 OUT11 VSS OSS_ESD_5V_DIO
X14 P13 VDD HIZ13 OUT13 VSS OSS_ESD_5V_DIO
X15 P1 VDD HIZ1 OUT1 VSS OSS_ESD_5V_DIO
X16 P15 VDD HIZ15 OUT15 VSS OSS_ESD_5V_DIO
X17 VDD VSS OSS_ESD_5V_VDD
X18 P2 VDD HIZ2 OUT2 VSS OSS_ESD_5V_DIO
X22 P3 VDD HIZ3 OUT3 VSS OSS_ESD_5V_DIO
.ends OSS_FRAME_GIO
